// Design: CMOS/Inverter_testbench
simulator lang=spectre
global 0
parameters VDD=3.3 VG=3.3
include "/export/opt/ncsu-cdk-1.6.0.beta/models/spectre/standalone/tsmc35N.m"
include "/export/opt/ncsu-cdk-1.6.0.beta/models/spectre/standalone/tsmc35P.m"

// CMOS/Inverter/schematic
subckt Inverter GND IN OUT VDD
    P0 (OUT IN VDD VDD) tsmc35P w=12.0u l=1.6u m=1 region=sat
    N0 (OUT IN GND GND) tsmc35N w=4u l=1.6u m=1 region=sat
ends Inverter

// CMOS/Inverter_testbench/schematic
I0 (0 net1 net3 net2) Inverter
C0 (net3 0) capacitor c=50f m=1
V0 (net2 0) vsource type=dc dc=VDD
VG (net1 0) vsource type=dc dc=VG
simulatorOptions options temp=27
dc dc param=VG start=0 stop=3.3 step=0.1
