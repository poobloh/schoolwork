simulator( 'spectre )
design(	 "/home/castro/cadence/simulation/Inverter_testbench/spectre/schematic/netlist/netlist")
resultsDir( "/home/castro/cadence/simulation/Inverter_testbench/spectre/schematic" )
analysis('dc ?saveOppoint t  ?dev "/V1"  ?param "left"
		?start "0"  ?stop "3.3"  )
envOption(
	'analysisOrder  list("dc")
)
save( 'i "/I0/OUT" )
temp( 27 )
run()
selectResult( 'dc )
plot(getData("/I0/OUT") )
modelFile(
    '("/export/opt/ncsu-cdk-1.6.0.beta/models/spectre/standalone/tsmc35N.m" "")
    '("/export/opt/ncsu-cdk-1.6.0.beta/models/spectre/standalone/tsmc35P.m" "")
)
analysis('dc ?param "VG"  )
save( 'i "/V1/PLUS" )
run()
selectResult( 'dc )
plot(getData("/I0/OUT") getData("/V1/PLUS") )
modelFile(
    '("/export/opt/ncsu-cdk-1.6.0.beta/models/spectre/standalone/tsmc35N.m" "")
    '("/export/opt/ncsu-cdk-1.6.0.beta/models/spectre/standalone/tsmc35P.m" "")
)
analysis('dc ?param "V1"  )
run()
selectResult( 'dc )
plot(getData("/I0/OUT") getData("/V1/PLUS") )
modelFile(
    '("/export/opt/ncsu-cdk-1.6.0.beta/models/spectre/standalone/tsmc35N.m" "")
    '("/export/opt/ncsu-cdk-1.6.0.beta/models/spectre/standalone/tsmc35P.m" "")
)
analysis('dc ?saveOppoint nil  ?dev ""  ?param "VG"  )
desVar(	  "VG" 3.3	)
desVar(	  "VDD" 3.3	)
save( 'i "/C0/PLUS" "/VG/PLUS" )
save( 'i /I0/OUT /V1/PLUS )
run()
selectResult( 'dc )
plot(getData("/C0/PLUS") getData("/VG/PLUS") )
modelFile(
    '("/export/opt/ncsu-cdk-1.6.0.beta/models/spectre/standalone/tsmc35N.m" "")
    '("/export/opt/ncsu-cdk-1.6.0.beta/models/spectre/standalone/tsmc35P.m" "")
)
save( 'i /C0/PLUS /VG/PLUS )
run()
selectResult( 'dc )
plot(getData("/net1") getData("/net3") )
